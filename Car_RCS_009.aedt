# Ansys Electronics Desktop project, version 2024.2
materials:
  vacuum: permittivity=1
  pec: conductivity=1e+30

design Theta (HFSS, HFSS Modal Network, model units mm)
geometry:
  UserLibraryTavanII1_Unnamed_1, UserLibraryTavanII1_Unnamed_1_1, UserLibraryTavanII1_Unnamed_1_2, UserLibraryTavanII1_Unnamed_1_3 [non-model] = imported_body(C:\Users\kinoz\Downloads\User Library-Tavan II-1.sat)
  UserLibraryTavanII1_Unnamed_1_4..UserLibraryTavanII1_Unnamed_1_12, UserLibraryTavanII1_Unnamed_1_14..UserLibraryTavanII1_Unnamed_1_32 = imported_body(C:\Users\kinoz\Downloads\User Library-Tavan II-1.sat)
  [UserLibraryTavanII1_Unnamed_1, UserLibraryTavanII1_Unnamed_1_1..UserLibraryTavanII1_Unnamed_1_12, UserLibraryTavanII1_Unnamed_1_14..UserLibraryTavanII1_Unnamed_1_32].rotate(axis=X, angle=90deg)
  [UserLibraryTavanII1_Unnamed_1, UserLibraryTavanII1_Unnamed_1_1..UserLibraryTavanII1_Unnamed_1_12, UserLibraryTavanII1_Unnamed_1_14..UserLibraryTavanII1_Unnamed_1_32].rotate(axis=Z, angle=90deg)
  [UserLibraryTavanII1_Unnamed_1, UserLibraryTavanII1_Unnamed_1_1..UserLibraryTavanII1_Unnamed_1_12, UserLibraryTavanII1_Unnamed_1_14..UserLibraryTavanII1_Unnamed_1_32].move(-800mm, -400mm, 0mm)
  RadiatingSurface [vacuum] = region(absolute_offset=99.700897mm on all sides)
  [UserLibraryTavanII1_Unnamed_1, UserLibraryTavanII1_Unnamed_1_1..UserLibraryTavanII1_Unnamed_1_12, UserLibraryTavanII1_Unnamed_1_14..UserLibraryTavanII1_Unnamed_1_32].move(200mm, 400mm, 0mm)
  [UserLibraryTavanII1_Unnamed_1, UserLibraryTavanII1_Unnamed_1_1..UserLibraryTavanII1_Unnamed_1_12, UserLibraryTavanII1_Unnamed_1_14..UserLibraryTavanII1_Unnamed_1_32].move(0mm, 0mm, 1200mm)
  [UserLibraryTavanII1_Unnamed_1, UserLibraryTavanII1_Unnamed_1_1..UserLibraryTavanII1_Unnamed_1_12, UserLibraryTavanII1_Unnamed_1_14..UserLibraryTavanII1_Unnamed_1_32].rotate(axis=Z, angle=180deg)
  group UserLibraryTavanII1 = UserLibraryTavanII1_Unnamed_1, UserLibraryTavanII1_Unnamed_1_1..UserLibraryTavanII1_Unnamed_1_12, UserLibraryTavanII1_Unnamed_1_14..UserLibraryTavanII1_Unnamed_1_32
boundaries and excitations:
  PerfE1: Perfect E Objects=[UserLibraryTavanII1_Unnamed_1_4..UserLibraryTavanII1_Unnamed_1_12, UserLibraryTavanII1_Unnamed_1_14..UserLibraryTavanII1_Unnamed_1_32]
  Open1: Radiation Objects=RadiatingSurface
  IncPWave1: Plane Incident Wave PhiStart=0deg PhiStop=360deg PhiPoints=181 ThetaStart=90deg ThetaStop=90deg ThetaPoints=1 EoPhi=0 EoTheta=1 OriginX=0mm OriginY=0mm OriginZ=0mm IsPropagating
setups:
  Setup1: HfssDriven Frequency=1.009GHz MaxDeltaE=0.1 MaximumPasses=6 MinimumPasses=1 MinimumConvergedPasses=1 PercentRefinement=30 BasisOrder=1 DrivenSolverType="Direct Solver"
source amplitudes:
  IncPWave1:1: 1 0deg
radiation setups:
  3D: Infinite Sphere Theta=0deg..180deg step 2deg Phi=-180deg..180deg step 2deg
  Elevation: Infinite Sphere Theta=-180deg..180deg step 1deg Phi=0deg..90deg step 90deg
  Azimuth: Infinite Sphere Theta=90deg..90deg step 0deg Phi=-180deg..180deg step 1deg
reports:
  Monostatic RCS Plot 1: dB(MonostaticRCSTotal) vs IWavePhi, IWaveTheta on Setup1 : LastAdaptive [Freq=1.009GHz]

design Phi (HFSS, HFSS Modal Network, model units mm)
geometry:
  UserLibraryTavanII1_Unnamed_1, UserLibraryTavanII1_Unnamed_1_1, UserLibraryTavanII1_Unnamed_1_2, UserLibraryTavanII1_Unnamed_1_3 [non-model] = imported_body(C:\Users\kinoz\Downloads\User Library-Tavan II-1.sat)
  UserLibraryTavanII1_Unnamed_1_4..UserLibraryTavanII1_Unnamed_1_12, UserLibraryTavanII1_Unnamed_1_14..UserLibraryTavanII1_Unnamed_1_32 = imported_body(C:\Users\kinoz\Downloads\User Library-Tavan II-1.sat)
  [UserLibraryTavanII1_Unnamed_1, UserLibraryTavanII1_Unnamed_1_1..UserLibraryTavanII1_Unnamed_1_12, UserLibraryTavanII1_Unnamed_1_14..UserLibraryTavanII1_Unnamed_1_32].rotate(axis=X, angle=90deg)
  [UserLibraryTavanII1_Unnamed_1, UserLibraryTavanII1_Unnamed_1_1..UserLibraryTavanII1_Unnamed_1_12, UserLibraryTavanII1_Unnamed_1_14..UserLibraryTavanII1_Unnamed_1_32].rotate(axis=Z, angle=90deg)
  [UserLibraryTavanII1_Unnamed_1, UserLibraryTavanII1_Unnamed_1_1..UserLibraryTavanII1_Unnamed_1_12, UserLibraryTavanII1_Unnamed_1_14..UserLibraryTavanII1_Unnamed_1_32].move(-800mm, -400mm, 0mm)
  RadiatingSurface [vacuum] = region(absolute_offset=99.700897mm on all sides)
  [UserLibraryTavanII1_Unnamed_1, UserLibraryTavanII1_Unnamed_1_1..UserLibraryTavanII1_Unnamed_1_12, UserLibraryTavanII1_Unnamed_1_14..UserLibraryTavanII1_Unnamed_1_32].move(200mm, 400mm, 0mm)
  [UserLibraryTavanII1_Unnamed_1, UserLibraryTavanII1_Unnamed_1_1..UserLibraryTavanII1_Unnamed_1_12, UserLibraryTavanII1_Unnamed_1_14..UserLibraryTavanII1_Unnamed_1_32].move(0mm, 0mm, 1200mm)
  [UserLibraryTavanII1_Unnamed_1, UserLibraryTavanII1_Unnamed_1_1..UserLibraryTavanII1_Unnamed_1_12, UserLibraryTavanII1_Unnamed_1_14..UserLibraryTavanII1_Unnamed_1_32].rotate(axis=Z, angle=180deg)
  group UserLibraryTavanII1 = UserLibraryTavanII1_Unnamed_1, UserLibraryTavanII1_Unnamed_1_1..UserLibraryTavanII1_Unnamed_1_12, UserLibraryTavanII1_Unnamed_1_14..UserLibraryTavanII1_Unnamed_1_32
boundaries and excitations:
  PerfE1: Perfect E Objects=[UserLibraryTavanII1_Unnamed_1_4..UserLibraryTavanII1_Unnamed_1_12, UserLibraryTavanII1_Unnamed_1_14..UserLibraryTavanII1_Unnamed_1_32]
  Open1: Radiation Objects=RadiatingSurface
  IncPWave1: Plane Incident Wave PhiStart=180deg PhiStop=180deg PhiPoints=1 ThetaStart=-90deg ThetaStop=90deg ThetaPoints=91 EoPhi=1 EoTheta=0 OriginX=0mm OriginY=0mm OriginZ=0mm IsPropagating
setups:
  Setup1: HfssDriven Frequency=1.009GHz MaxDeltaE=0.1 MaximumPasses=6 MinimumPasses=1 MinimumConvergedPasses=1 PercentRefinement=30 BasisOrder=1 DrivenSolverType="Direct Solver"
source amplitudes:
  IncPWave1:1: 1 0deg
radiation setups:
  3D: Infinite Sphere Theta=0deg..180deg step 2deg Phi=-180deg..180deg step 2deg
  Elevation: Infinite Sphere Theta=-180deg..180deg step 1deg Phi=0deg..90deg step 90deg
  Azimuth: Infinite Sphere Theta=90deg..90deg step 0deg Phi=-180deg..180deg step 1deg
reports:
  Monostatic RCS Plot 1: dB(MonostaticRCSTotal) vs IWavePhi, IWaveTheta on Setup1 : LastAdaptive [Freq=1.009GHz]
